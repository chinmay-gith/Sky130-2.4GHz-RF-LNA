** sch_path: /home/azmuth/Projects/Sky130_RF_Receiver/lna/lna_sky130_match_test.sch
**.subckt lna_sky130_match_test RF_OUT
*.opin RF_OUT
XM1 RF_OUT net2 net1 GND sky130_fd_pr__nfet_01v8 L=0.15 W=40 nf=4 ad='int((nf+1)/2) * W/nf * 0.29' as='int((nf+2)/2) * W/nf * 0.29'
+ pd='2*int((nf+1)/2) * (W/nf + 0.29)' ps='2*int((nf+2)/2) * (W/nf + 0.29)' nrd='0.29 / W' nrs='0.29 / W'
+ sa=0 sb=0 sd=0 mult=1 m=1
Lload VDD RF_OUT 3n m=1
Cload VDD RF_OUT 1.5p m=1
Ls net1 GND 0.5n m=1
Lg net2 net4 2n m=1
Rs net3 net5 50 m=1
V1 net5 GND dc 0 ac 1
Rbias VBIAS net2 10k m=1
Rload RF_OUT GND 50 m=1
VB VBIAS GND 0.9
VDD1 VDD GND 1.8
C1 net3 net4 1p m=1
**** begin user architecture code

* --- Sky130 LNA testbench directives ---
* Adjust this include path to match your local sky130 install:
.lib /home/azmuth/.volare/volare/volare/sky130/versions/0fe599b2afb6708d281543108caf8310912f54af/sky130A/libs.tech/combined/sky130.lib.spice tt
.control

alter Rload 50
alter Lg 80n
alter Lload 3n
alter Cload 1.4p

alter C1 0.5p
ac lin 1 2.4g 2.4g
let z05 = 1/(-i(V1))
let s05 = (z05-50)/(z05+50)
let s05db = 20*log10(abs(s05))
print z05
print s05db

alter C1 0.75p
ac lin 1 2.4g 2.4g
let z075 = 1/(-i(V1))
let s075 = (z075-50)/(z075+50)
let s075db = 20*log10(abs(s075))
print z075
print s075db

alter C1 1p
ac lin 1 2.4g 2.4g
let z1 = 1/(-i(V1))
let s1 = (z1-50)/(z1+50)
let s1db = 20*log10(abs(s1))
print z1
print s1db

alter C1 1.25p
ac lin 1 2.4g 2.4g
let z125 = 1/(-i(V1))
let s125 = (z125-50)/(z125+50)
let s125db = 20*log10(abs(s125))
print z125
print s125db

alter C1 1.5p
ac lin 1 2.4g 2.4g
let z15 = 1/(-i(V1))
let s15 = (z15-50)/(z15+50)
let s15db = 20*log10(abs(s15))
print z15
print s15db

alter C1 2p
ac lin 1 2.4g 2.4g
let z2 = 1/(-i(V1))
let s2 = (z2-50)/(z2+50)
let s2db = 20*log10(abs(s2))
print z2
print s2db

.endc
**** end user architecture code
**.ends
.GLOBAL GND
.end
