** sch_path: /home/azmuth/Projects/Sky130_RF_Receiver/lna/lna_sky130.sch
**.subckt lna_sky130 RF_OUT
*.opin RF_OUT
XM1 RF_OUT net2 net1 GND sky130_fd_pr__nfet_01v8 L=0.15 W=40 nf=4 ad='int((nf+1)/2) * W/nf * 0.29' as='int((nf+2)/2) * W/nf * 0.29'
+ pd='2*int((nf+1)/2) * (W/nf + 0.29)' ps='2*int((nf+2)/2) * (W/nf + 0.29)' nrd='0.29 / W' nrs='0.29 / W'
+ sa=0 sb=0 sd=0 mult=1 m=1
Lload VDD RF_OUT 3n m=1
Cload VDD RF_OUT 1.5p m=1
Ls net1 GND 0.5n m=1
Lg net2 net4 2n m=1
Rs net3 net5 50 m=1
V1 net5 GND dc 0 ac 1
Rbias VBIAS net2 10k m=1
Rload RF_OUT GND 1000 m=1
VB VBIAS GND 0.9
VDD1 VDD GND 1.8
C1 net3 net4 1p m=1
**** begin user architecture code

* --- Sky130 LNA testbench directives ---
* Adjust this include path to match your local sky130 install:
.lib /home/azmuth/.volare/volare/volare/sky130/versions/0fe599b2afb6708d281543108caf8310912f54af/sky130A/libs.tech/combined/sky130.lib.spice tt
 .control

alter Rload 1000

alter Cload 1.0p
ac lin 1 2.4g 2.4g
let g10 = 20*log10(abs(v(RF_OUT)))
print g10

alter Cload 1.2p
ac lin 1 2.4g 2.4g
let g12 = 20*log10(abs(v(RF_OUT)))
print g12

alter Cload 1.5p
ac lin 1 2.4g 2.4g
let g15 = 20*log10(abs(v(RF_OUT)))
print g15

alter Cload 1.8p
ac lin 1 2.4g 2.4g
let g18 = 20*log10(abs(v(RF_OUT)))
print g18

alter Cload 2.0p
ac lin 1 2.4g 2.4g
let g20 = 20*log10(abs(v(RF_OUT)))
print g20

.endc

**** end user architecture code
**.ends
.GLOBAL GND
.end
