** sch_path: /home/azmuth/Projects/Sky130_RF_Receiver/lna/lna_sky130.sch
**.subckt lna_sky130 RF_OUT
*.opin RF_OUT
XM1 RF_OUT net2 net1 GND sky130_fd_pr__nfet_01v8 L=0.15 W=40 nf=4 ad='int((nf+1)/2) * W/nf * 0.29' as='int((nf+2)/2) * W/nf * 0.29'
+ pd='2*int((nf+1)/2) * (W/nf + 0.29)' ps='2*int((nf+2)/2) * (W/nf + 0.29)' nrd='0.29 / W' nrs='0.29 / W'
+ sa=0 sb=0 sd=0 mult=1 m=1
Lload VDD RF_OUT 3n m=1
Cload VDD RF_OUT 1.5p m=1
Ls net1 GND 0.5n m=1
Lg net2 net4 2n m=1
Rs net3 net5 50 m=1
V1 net5 GND dc 0 ac 1
Rbias VBIAS net2 10k m=1
Rload RF_OUT GND 1000 m=1
VB VBIAS GND 0.9
VDD1 VDD GND 1.8
C1 net3 net4 1p m=1
**** begin user architecture code

* --- Sky130 LNA testbench directives ---
* Adjust this include path to match your local sky130 install:
.lib /home/azmuth/.volare/volare/volare/sky130/versions/0fe599b2afb6708d281543108caf8310912f54af/sky130A/libs.tech/combined/sky130.lib.spice tt
 .control

alter Cload 1.5p

alter Rload 400
ac lin 1 2.4g 2.4g
let g400 = 20*log10(abs(v(RF_OUT)))
print g400

alter Rload 500
ac lin 1 2.4g 2.4g
let g500 = 20*log10(abs(v(RF_OUT)))
print g500

alter Rload 600
ac lin 1 2.4g 2.4g
let g600 = 20*log10(abs(v(RF_OUT)))
print g600

alter Rload 700
ac lin 1 2.4g 2.4g
let g700 = 20*log10(abs(v(RF_OUT)))
print g700

alter Rload 800
ac lin 1 2.4g 2.4g
let g800 = 20*log10(abs(v(RF_OUT)))
print g800

alter Rload 900
ac lin 1 2.4g 2.4g
let g900 = 20*log10(abs(v(RF_OUT)))
print g900

alter Rload 1000
ac lin 1 2.4g 2.4g
let g1000 = 20*log10(abs(v(RF_OUT)))
print g1000

.endc

**** end user architecture code
**.ends
.GLOBAL GND
.end
